V1 1 0 5
R1 1 2 1000
R2 2 3 2000
R3 3 0 1000
